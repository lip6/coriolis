* Spice description of sff3_x4
* Spice driver version 2127473576
* Date ( dd/mm/yyyy hh:mm:ss ):  1/08/2024 at 18:58:30

* INTERF ck cmd0 cmd1 i0 i1 i2 q vdd vss

.subckt sff3_x4 16 18 24 17 22 23 8 25 30
* NET 8 = q
* NET 9 = y
* NET 10 = sff_s
* NET 12 = ckr
* NET 13 = sff_m
* NET 16 = ck
* NET 17 = i0
* NET 18 = cmd0
* NET 19 = nckr
* NET 22 = i1
* NET 23 = i2
* NET 24 = cmd1
* NET 25 = vdd
* NET 29 = u
* NET 30 = vss
Mtr_00042 9 13 25 25 sky130_fd_pr__pfet_01v8__model L=0.15U W=1.02U AS=0.2958P AD=0.2958P PS=2.62U PD=2.62U
Mtr_00041 10 12 1 25 sky130_fd_pr__pfet_01v8__model L=0.15U W=1.26U AS=0.3654P AD=0.3654P PS=3.1U PD=3.1U
Mtr_00040 7 27 29 25 sky130_fd_pr__pfet_01v8__model L=0.15U W=1.14U AS=0.3306P AD=0.3306P PS=2.86U PD=2.86U
Mtr_00039 29 17 4 25 sky130_fd_pr__pfet_01v8__model L=0.15U W=1.14U AS=0.3306P AD=0.3306P PS=2.86U PD=2.86U
Mtr_00038 6 23 5 25 sky130_fd_pr__pfet_01v8__model L=0.15U W=1.14U AS=0.3306P AD=0.3306P PS=2.86U PD=2.86U
Mtr_00037 5 22 7 25 sky130_fd_pr__pfet_01v8__model L=0.15U W=1.14U AS=0.3306P AD=0.3306P PS=2.86U PD=2.86U
Mtr_00036 25 18 20 25 sky130_fd_pr__pfet_01v8__model L=0.15U W=0.78U AS=0.2262P AD=0.2262P PS=2.14U PD=2.14U
Mtr_00035 9 19 10 25 sky130_fd_pr__pfet_01v8__model L=0.15U W=1.02U AS=0.2958P AD=0.2958P PS=2.62U PD=2.62U
Mtr_00034 3 9 25 25 sky130_fd_pr__pfet_01v8__model L=0.15U W=1.02U AS=0.2958P AD=0.2958P PS=2.62U PD=2.62U
Mtr_00033 13 19 3 25 sky130_fd_pr__pfet_01v8__model L=0.15U W=1.02U AS=0.2958P AD=0.2958P PS=2.62U PD=2.62U
Mtr_00032 25 10 8 25 sky130_fd_pr__pfet_01v8__model L=0.15U W=2.46U AS=0.7134P AD=0.7134P PS=5.5U PD=5.5U
Mtr_00031 8 10 25 25 sky130_fd_pr__pfet_01v8__model L=0.15U W=2.46U AS=0.7134P AD=0.7134P PS=5.5U PD=5.5U
Mtr_00030 29 24 6 25 sky130_fd_pr__pfet_01v8__model L=0.15U W=1.14U AS=0.3306P AD=0.3306P PS=2.86U PD=2.86U
Mtr_00029 25 29 2 25 sky130_fd_pr__pfet_01v8__model L=0.15U W=1.02U AS=0.2958P AD=0.2958P PS=2.62U PD=2.62U
Mtr_00028 2 12 13 25 sky130_fd_pr__pfet_01v8__model L=0.15U W=1.02U AS=0.2958P AD=0.2958P PS=2.62U PD=2.62U
Mtr_00027 25 20 5 25 sky130_fd_pr__pfet_01v8__model L=0.15U W=1.14U AS=0.3306P AD=0.3306P PS=2.86U PD=2.86U
Mtr_00026 4 18 25 25 sky130_fd_pr__pfet_01v8__model L=0.15U W=1.14U AS=0.3306P AD=0.3306P PS=2.86U PD=2.86U
Mtr_00025 25 16 19 25 sky130_fd_pr__pfet_01v8__model L=0.15U W=1.02U AS=0.2958P AD=0.2958P PS=2.62U PD=2.62U
Mtr_00024 12 19 25 25 sky130_fd_pr__pfet_01v8__model L=0.15U W=1.02U AS=0.2958P AD=0.2958P PS=2.62U PD=2.62U
Mtr_00023 27 24 25 25 sky130_fd_pr__pfet_01v8__model L=0.15U W=0.78U AS=0.2262P AD=0.2262P PS=2.14U PD=2.14U
Mtr_00022 1 8 25 25 sky130_fd_pr__pfet_01v8__model L=0.15U W=1.26U AS=0.3654P AD=0.3654P PS=3.1U PD=3.1U
Mtr_00021 11 19 10 30 sky130_fd_pr__nfet_01v8__model L=0.15U W=0.66U AS=0.1914P AD=0.1914P PS=1.9U PD=1.9U
Mtr_00020 15 29 30 30 sky130_fd_pr__nfet_01v8__model L=0.15U W=0.54U AS=0.1566P AD=0.1566P PS=1.66U PD=1.66U
Mtr_00019 13 19 15 30 sky130_fd_pr__nfet_01v8__model L=0.15U W=0.54U AS=0.1566P AD=0.1566P PS=1.66U PD=1.66U
Mtr_00018 30 9 14 30 sky130_fd_pr__nfet_01v8__model L=0.15U W=0.54U AS=0.1566P AD=0.1566P PS=1.66U PD=1.66U
Mtr_00017 26 22 31 30 sky130_fd_pr__nfet_01v8__model L=0.15U W=0.54U AS=0.1566P AD=0.1566P PS=1.66U PD=1.66U
Mtr_00016 28 23 26 30 sky130_fd_pr__nfet_01v8__model L=0.15U W=0.54U AS=0.1566P AD=0.1566P PS=1.66U PD=1.66U
Mtr_00015 30 19 12 30 sky130_fd_pr__nfet_01v8__model L=0.15U W=0.54U AS=0.1566P AD=0.1566P PS=1.66U PD=1.66U
Mtr_00014 21 20 30 30 sky130_fd_pr__nfet_01v8__model L=0.15U W=0.54U AS=0.1566P AD=0.1566P PS=1.66U PD=1.66U
Mtr_00013 30 24 27 30 sky130_fd_pr__nfet_01v8__model L=0.15U W=0.42U AS=0.1218P AD=0.1218P PS=1.42U PD=1.42U
Mtr_00012 9 13 30 30 sky130_fd_pr__nfet_01v8__model L=0.15U W=0.54U AS=0.1566P AD=0.1566P PS=1.66U PD=1.66U
Mtr_00011 10 12 9 30 sky130_fd_pr__nfet_01v8__model L=0.15U W=0.54U AS=0.1566P AD=0.1566P PS=1.66U PD=1.66U
Mtr_00010 31 24 29 30 sky130_fd_pr__nfet_01v8__model L=0.15U W=0.54U AS=0.1566P AD=0.1566P PS=1.66U PD=1.66U
Mtr_00009 14 12 13 30 sky130_fd_pr__nfet_01v8__model L=0.15U W=0.54U AS=0.1566P AD=0.1566P PS=1.66U PD=1.66U
Mtr_00008 20 18 30 30 sky130_fd_pr__nfet_01v8__model L=0.15U W=0.42U AS=0.1218P AD=0.1218P PS=1.42U PD=1.42U
Mtr_00007 29 17 21 30 sky130_fd_pr__nfet_01v8__model L=0.15U W=0.54U AS=0.1566P AD=0.1566P PS=1.66U PD=1.66U
Mtr_00006 30 18 26 30 sky130_fd_pr__nfet_01v8__model L=0.15U W=0.54U AS=0.1566P AD=0.1566P PS=1.66U PD=1.66U
Mtr_00005 30 16 19 30 sky130_fd_pr__nfet_01v8__model L=0.15U W=0.54U AS=0.1566P AD=0.1566P PS=1.66U PD=1.66U
Mtr_00004 29 27 28 30 sky130_fd_pr__nfet_01v8__model L=0.15U W=0.54U AS=0.1566P AD=0.1566P PS=1.66U PD=1.66U
Mtr_00003 30 8 11 30 sky130_fd_pr__nfet_01v8__model L=0.15U W=0.66U AS=0.1914P AD=0.1914P PS=1.9U PD=1.9U
Mtr_00002 30 10 8 30 sky130_fd_pr__nfet_01v8__model L=0.15U W=1.26U AS=0.3654P AD=0.3654P PS=3.1U PD=3.1U
Mtr_00001 8 10 30 30 sky130_fd_pr__nfet_01v8__model L=0.15U W=1.26U AS=0.3654P AD=0.3654P PS=3.1U PD=3.1U
C27 5 30 6.69675e-16
C24 8 30 2.17433e-15
C23 9 30 2.2951e-15
C22 10 30 2.35568e-15
C20 12 30 4.13912e-15
C19 13 30 2.60658e-15
C16 16 30 6.34009e-16
C15 17 30 8.49567e-16
C14 18 30 1.27501e-15
C13 19 30 3.72606e-15
C12 20 30 2.11295e-15
C10 22 30 8.49096e-16
C9 23 30 7.28271e-16
C8 24 30 1.9238e-15
C7 25 30 7.44814e-15
C6 26 30 6.69675e-16
C5 27 30 1.85648e-15
C3 29 30 4.68986e-15
C2 30 30 6.6606e-15
.ends sff3_x4
